* D ordering run R069 -- BEHAVIOURAL / PRELIMINARY (free-rail mode, ADAR1000 register reset)
* rails on/off (ms): +3V3_AUX [(3.1695357235447013, 25.673243602287855), (29.18405336178903, None)]; +1V8_DIG [(4.600809506691179, None)]; +3V3_RF [(2.044696400290957, None)]; +5V_PA [(5.398030713027733, 23.623465868812236), (29.997973186087638, None)]; -5V_BF [(5.120322123095797, None)]; -3V3_SW [(1.381826630677255, 11.517878277177703), (31.64109483204477, None)]
.include h2c_plant.inc
.param free=1 adar_reset=1 tr_aux=0.511 tr_18=0.609 tr_rf=2.893 tr_pa=2.656 tr_n5=3.776 tr_n3=1.651
VVIN vin 0 PWL(0 12)
VE3 fw_en3v3 0 1
VE5 fw_en5vpa 0 1
VEN fw_enneg 0 1
VKL ldo5_kill 0 0
VRK rf_kill 0 0
VWD fw_wdt 0 PWL(0 1 0.0301939242 1 0.0301949242 0 0.0308117876 0 0.0308127876 1)
VPA fw_pa_en 0 PWL(0 0 0.00921017043 0 0.00921117043 1 0.0145208865 1 0.0145218865 0 0.018581248 0 0.018582248 1 0.0189687557 1 0.0189697557 0)
VD1 dac1 0 PWL(0 0 0.00413633567 0 0.00413733567 -1.75 0.00869561321 -1.75 0.00869661321 -1.75 0.00901017043 -1.75 0.00901117043 -1.75 0.0100101704 -1.75 0.0100111704 -1.1 0.0136066632 -1.1 0.0136076632 -1.75)
VD2 dac2 0 PWL(0 0 0.00413633567 0 0.00413733567 -1.75 0.00869561321 -1.75 0.00869661321 -1.75 0.00901017043 -1.75 0.00901117043 -1.75 0.0100101704 -1.75 0.0100111704 -1.1 0.0136066632 -1.1 0.0136076632 -1.75)
VD3 dac3 0 PWL(0 0 0.00413633567 0 0.00413733567 -1.75 0.00869561321 -1.75 0.00869661321 -1.75 0.00901017043 -1.75 0.00901117043 -1.75 0.0100101704 -1.75 0.0100111704 -1.1 0.0136066632 -1.1 0.0136076632 -1.75)
VD4 dac4 0 PWL(0 0 0.00413633567 0 0.00413733567 -1.75 0.00869561321 -1.75 0.00869661321 -1.75 0.00901017043 -1.75 0.00901117043 -1.75 0.0100101704 -1.75 0.0100111704 -1.1 0.0136066632 -1.1 0.0136076632 -1.75)
VTLW tlw 0 PWL(0 0 0.00413633567 0 0.00413733567 0.00413634 0.00869561321 0.00413634 0.00869661321 0.00869561 0.00901017043 0.00869561 0.00901117043 0.00901017 0.0100101704 0.00901017 0.0100111704 0.0100102 0.0136066632 0.0100102 0.0136076632 0.0136067)
VFR1 fr_aux 0 PWL(0 0 0.00316953572 0 0.00317053572 1 0.0256732436 1 0.0256742436 0 0.0291840534 0 0.0291850534 1)
VFR2 fr_18 0 PWL(0 0 0.00460080951 0 0.00460180951 1)
VFR3 fr_rf 0 PWL(0 0 0.0020446964 0 0.0020456964 1)
VFR4 fr_pa 0 PWL(0 0 0.00539803071 0 0.00539903071 1 0.0236234659 1 0.0236244659 0 0.0299979732 0 0.0299989732 1)
VFR5 fr_n5 0 PWL(0 0 0.00512032212 0 0.00512132212 1)
VFR6 fr_n3 0 PWL(0 0 0.00138182663 0 0.00138282663 1 0.0115178783 1 0.0115188783 0 0.0316410948 0 0.0316420948 1)
.tran 1u 0.04 0 2u
.end
