* S5A_WATCHDOG_TX -- BEHAVIOURAL, datasheet timing (see H2C_SEQUENCING_SIM.md)
* Watchdog: WDT_OK low 142.0-142.5 ms while transmitting; 142.6/142.7 ms MCU_PA_EN toggled with gates
* still ON (must NOT re-arm); 142.8 ms gates OFF -1.75 V, 142.9/143.0 ms MCU_PA_EN toggled (re-arm),
* 143.6 ms gates ON -1.1 V (TX).
* Common: VIN 0->12 V in 1 ms; MCU at 8 ms asserts PWR_EN_3V3/5VPA/NEG; PA_BIAS OFF -1.75 V at 140.0 ms,
* MCU_PA_EN at 140.2 ms, gates ON -1.1 V at 141.0 ms unless stated.
.include h2c_plant.inc
VVIN vin 0 PWL(0 0 1m 12)
VE3 fw_en3v3  0 PWL(0 0 8m 0 8.001m 1)
VE5 fw_en5vpa 0 PWL(0 0 8m 0 8.001m 1)
VEN fw_enneg  0 PWL(0 0 8m 0 8.001m 1)
VWD fw_wdt    0 PWL(0 0 8m 0 8.001m 1 142m 1 142.001m 0 142.5m 0 142.501m 1)
VKL ldo5_kill 0 0
VRK rf_kill   0 0
VTLW tlw 0 0
VFR1 fr_aux 0 0
VFR2 fr_18 0 0
VFR3 fr_rf 0 0
VFR4 fr_pa 0 0
VFR5 fr_n5 0 0
VFR6 fr_n3 0 0
VPA fw_pa_en  0 PWL(0 0 140.2m 0 140.201m 1 142.6m 1 142.601m 0 142.7m 0 142.701m 1 142.9m 1 142.901m 0 143m 0 143.001m 1)
VD1 dac1 0 PWL(0 0 140m 0 140.001m -1.75 141m -1.75 141.001m -1.1 142.8m -1.1 142.801m -1.75 143.6m -1.75 143.601m -1.1)
VD2 dac2 0 PWL(0 0 140m 0 140.001m -1.75 141m -1.75 141.001m -1.1 142.8m -1.1 142.801m -1.75 143.6m -1.75 143.601m -1.1)
VD3 dac3 0 PWL(0 0 140m 0 140.001m -1.75 141m -1.75 141.001m -1.1 142.8m -1.1 142.801m -1.75 143.6m -1.75 143.601m -1.1)
VD4 dac4 0 PWL(0 0 140m 0 140.001m -1.75 141m -1.75 141.001m -1.1 142.8m -1.1 142.801m -1.75 143.6m -1.75 143.601m -1.1)
.tran 1u 144m 0 2u
.end
